/* Hafnium-Oxide Ferroelectric Capacitor
 *
 * Models the  polarization switching, capacitance and leakage current of a HZO FeCap.
 */

`include "constants.vams"
`include "disciplines.vams"
`define P_ME    9.1093837e-31

//(* compact_module *)
module heracles(te, be);
    // Ports
    inout te, be;

    // Nodes
    (* desc="Top electrode" *)
    electrical te;
    (* desc="Bottom electrode" *)
    electrical be;
    (* desc="Internal node for the bottom electrode interface" *)
    electrical n_be;
    (* desc="Internal node for the depletion layer" *)
    electrical n_int;
    (* desc="Internal node, state variable P" *)
    electrical n1;

    // Physical Parameters
    (* desc="Device area", units="m^2" *)
    parameter real area = 625e-12    from[1e-18:inf);
    (* desc="Portion of ferroelectric domains", units="1" *)
    parameter real p_ferro = 0.6   from[0:1];
    (* desc="Ferroelectric layer thickness", units="m" *)
    parameter real t_fe = 9.8e-9    from[1e-9:5e-8];
    (* desc="Interface layer thickness", units="m" *)
    parameter real t_int = 1.5e-9    from[1e-10:2e-8];
    (* desc="Relative permittivity of orthorhombic HZO" *)
    parameter real eps_fe = 70    from[1:100];
    (* desc="Relative permittivity of monoclinic HZO" *)
    parameter real eps_de = 20    from[1:100];
    (* desc="Relative permittivity of interface layer" *)
    parameter real eps_int = 90    from[1:500];
    (* desc="Energy barrier height", units="eV" *)
    parameter real w_b = 1.05      from(0:inf);
    (* desc="Ion distance", units="m^2" *)
    parameter real d_e = 7.5e-9    from(0:inf);
    (* desc="Offset electric field", units="V/m" *)
    parameter real e_off = 2e7    from[-1e9:1e9];
    (* desc="Saturation polarization density", units="C/m^2" *)
    parameter real p_s = 27e-2    from[1e-3:1];
    (* desc="Carrrier density in interface depletion region", units="m" *)
    parameter real n_depl = 1.05e28   from[1e25:1e30];
    (* desc="Relative permittivity of the electrode"*)
    parameter real eps_depl = 3.6   from(0:100];
    (* desc="Fixed charge at depletion/ferrolectric interface"*)
    parameter real q_fix_depl_u = -9.8e-2   from[-1:1];
    (* desc="Fixed charge at depletion/ferrolectric interface"*)
    parameter real q_fix_depl_d = 9.8e-2   from[-1:1];

    // Fowler-Nordheim and TAT conduction parameters
    (* desc="Electron effective mass in the interface layer" *)
    parameter real m_eff_int = 1     from[0.01:inf);
    (* desc="Electron effective mass in the ferroelectric layer" *)
    parameter real m_eff_fe = 0.1     from[0.01:inf);
    (* desc="Electrode/HfO2 Energy barrier height", units="eV" *)
    parameter real phi_b_fe = 2        from(0:5];
    (* desc="Electrode/Interface Energy barrier height", units="eV" *)
    parameter real phi_b_int = 0.65  from(0:5];
    (*desc="Density of traps in the ferroelectric layer", units="m^-3"*)
    parameter real n_tr_fe = 1e25        from[1e18:1e28];
    (*desc="Trap depth", units="eV"*)
    parameter real w_tr_t = 2.1      from[0:5];
    (*desc="TAT characteristic length", units="m"*)
    parameter real x_c = 5e-9      from[1e-10:1e-7];
    (*desc="Trap relaxation energy", units="eV"*)
    parameter real w_tr_rel = 1.19      from[0:5];
    (*desc="Trap DOS", units="m"*)
    parameter real dos_trap = 5e32      from[1e-10:1e40];

    // Monte-Carlo variables, see model parameter file
    (* cds_inherited_parameter *)
    parameter real area_mc = 0;
    (* cds_inherited_parameter *)
    parameter real t_fe_mc = 0;
    (* cds_inherited_parameter *)
    parameter real t_int_mc = 0;
    (* cds_inherited_parameter *)
    parameter real p_s_mc = 0;
    (* cds_inherited_parameter *)
    parameter real n_depl_mc = 0;

    // Variables
    (* desc="Current densities", units="A/m^2" *)
    real i_cfe, i_cde, i_cint, i_p, i_leakp, i_leakbe, i_t, i_tat;
    (* desc="Occupation probability of down polarization state", units="1" *)
    real p;
    (* desc="Ferroelectric Polarization", units="F/m^2" *)
    real pol;
    (* desc="Transition rates" *)
    real k_plus, k_minus;
    (* desc="Energy barrier shift", units="eV" *)
    real w_e;
    (* desc="Capacitance densities", units="F/m^2" *)
    real c_fe, c_de, c_int, c_depl_u, c_depl_d, c_depl_tot;
    (* desc="Electric fields", units="V/m" *)
    real e_fe, e_be, e_leakage;
    (* desc="Branch voltages", units="V" *)
    real v_fecap, v_be, v_int, v_leakage;
    (* desc="Voltage and E-field direction"*)
    real sign_vfe, sign_vbe;
    (* desc="Leakage current intermediate variables"*)
    real a_t, b_t, a_t_int, b_t_int;
    real x_tm, a_xtm, b_xtm, c_xtm, d_xtm, w_tr_c, w_tr_j, tau_c, tau_c_unbound, lambda_xtm;
    real sqrt_arg, x_tm_num, x_tm_den;

    // Branches
    branch(n_be, be) bottom;
    branch(te, n_int) interface;
    branch(te, n_be) leakage;
    branch(n_int, n_be) fecap;
    branch(te, n_be) dielectric;
    branch(n1) internal1;

    analog begin
        // State variable via internal node potential
        p = V(internal1);

        // Initial definitions
        c_fe = `P_EPS0 * eps_fe / (t_fe + t_fe_mc);
        c_de = `P_EPS0 * eps_de / (t_fe + t_fe_mc);
        c_int = `P_EPS0 * eps_int / (t_int + t_int_mc);
        c_depl_u = `P_EPS0 * eps_depl / abs(`P_EPS0 * eps_fe * e_fe + q_fix_depl_u) * `P_Q * (n_depl + n_depl_mc);
        c_depl_d = `P_EPS0 * eps_depl / abs(`P_EPS0 * eps_fe * e_fe + q_fix_depl_d) * `P_Q * (n_depl + n_depl_mc);
        c_depl_tot = (p * c_depl_d + (1 - p) * c_depl_u);
        pol = 2 * (p_s + p_s_mc) * p;
        e_fe = V(fecap) / (t_fe + t_fe_mc);
        e_be = $limit(V(bottom), "pnjlim", $vt, 5) / (t_int + t_int_mc);
        sign_vfe = $tanh(1e3 * V(fecap));
        sign_vbe = $tanh(1e3 * V(bottom));

        // Debugging variables
        v_fecap = V(fecap);
        v_be = V(bottom);
        v_int = V(interface);
        v_leakage = $limit(V(leakage), "pnjlim", $vt, 5);

        // Time constant
        w_e = (e_fe - e_off) * d_e;
        k_plus =  `P_K * $temperature / `P_H * limexp(-(w_b - w_e) * `P_Q / `P_K / $temperature);
        k_minus = `P_K * $temperature / `P_H * limexp(-(w_b + w_e) * `P_Q / `P_K / $temperature);

        // Ferroelectric leakage current - FN tunneling and Poole-Frenkel
        lambda_xtm = 1 / (2 * $sqrt(phi_b_fe * 2 * m_eff_fe * `P_ME * `P_Q / (`P_H**2) * 4 * `M_PI**2));
        a_xtm = 2 * w_tr_rel * t_fe * `P_K * $temperature;
        b_xtm = lambda_xtm * t_fe / w_tr_rel + lambda_xtm**2 / 4 / `P_Q * `P_K * $temperature;
        c_xtm = lambda_xtm * t_fe * (w_tr_t - w_tr_rel - phi_b_fe) / w_tr_rel;
        d_xtm = lambda_xtm * t_fe * `P_Q * (phi_b_fe - w_tr_t + w_tr_rel);
        sqrt_arg = (b_xtm * abs(v_leakage)**2 / (`P_Q / `P_K / $temperature) + c_xtm * abs(v_leakage) / (`P_Q / `P_K / $temperature) + 4 * t_fe**2);
        x_tm_num = a_xtm * ($sqrt(sqrt_arg) - 2 * a_xtm * t_fe + d_xtm * abs(v_leakage));
        x_tm_den = (lambda_xtm * `P_Q * v_leakage * v_leakage);
        x_tm = min(8e-8, x_tm_num / x_tm_den);
        w_tr_j = w_tr_t + abs(v_leakage) * x_tm / t_fe - phi_b_fe;
        w_tr_c = min(4, (w_tr_rel - w_tr_j)**2 / 4 / w_tr_rel);
        tau_c_unbound = 1 / (dos_trap * n_tr_fe * limexp(-x_tm / lambda_xtm - w_tr_c / `P_Q * `P_K * $temperature));
		tau_c = min(1e10, max(1e-20, tau_c_unbound));
        i_tat = $tanh(10*v_leakage) * `P_Q * n_tr_fe * x_c / 2 / tau_c;

        // Interface leakage current - FN tunneling
        a_t_int = ($pow(`P_Q,2)) / (8 * `M_PI * `P_H * phi_b_int);
        b_t_int = (8 * `M_PI / 3) * $sqrt(2 * (m_eff_int * `P_ME * $pow(`P_Q * phi_b_int, 3)) / ($pow(`P_H, 2) * $pow(`P_Q, 2)));
        i_leakbe = sign_vbe*a_t_int * $pow(e_be,2) * limexp(- b_t_int/abs(e_be));

        // Displacement current density
        i_cde = c_de * ddt(V(dielectric));
        i_cfe = c_fe * ddt(V(fecap));
        i_cint = c_int * ddt(V(bottom));

        // Polarization equation
        I(internal1) <+ ddt(p);
        I(internal1) <+ k_minus * p-k_plus * (1 - p);
        i_p = ddt(2 * (p_s + p_s_mc) * p);

        // Branch current update
        I(bottom) <+ i_cint * (area + area_mc);
        I(bottom) <+ i_leakbe * (area + area_mc);
        I(fecap) <+ i_cfe * p_ferro * (area + area_mc);
        I(fecap) <+ i_p * (area + area_mc);
        I(dielectric) <+ i_cde * (1 - p_ferro) * (area + area_mc);
        I(leakage) <+ i_tat * (area + area_mc);
        V(interface) <+ (2 * (p_s + p_s_mc) * p - (p_s - p_s_mc) + c_fe * V(fecap)) / c_depl_tot;

    end
endmodule
